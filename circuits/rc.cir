rc lowpass step response
v1 in 0 pulse(0 1 0 1n 1n 1 2)
r1 in out 1k
c1 out 0 1u
.tran 10u 5m
.end
